* This is an example of a sine stimulus from a first order delta sigma modulator
.lib /home/dguyon/audio_elex/audio_elex/hw/deltaSigmaDac/spice/deltaSigma_subc.lib
X51 drv_out drv_out_l drv_out_h drv_n_out_h drv_n_out_l ds_dac
.end
.options trtol=8 reltol=0.005
.control
save v(X51.clk_in) v(X51.rst_n_in) v(drv_out_h) v(drv_out_l)
tran 10n 2m
*fourier v(filt_out) 2k
*plot pwm_out-5 drv_out2-10 filt_out
plot drv_out_h drv_out_l-5
*linearize v(filt_out)
*linearize v(drv_out2)
*set specwindow=blackman
*fft v(filt_out)
*fft v(drv_out2)
*plot db(mag(v(filt_out))) ylimit -100 20
*plot db(mag(v(drv_out2))) xlog xlimit 1000 1Meg ylimit -100 20
write output_data.raw
.endc
